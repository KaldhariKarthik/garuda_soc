// =============================================================================
// gpio.rdl - register description of block 19, the GPIO (APB window 7,
// 0x4000_7000), with the four shim registers every peripheral window has.
//
// Source: GARUDA-GPIO-SPEC-001 section 6 and DECISIONS.md D-21. Two pins. The
// UVM register model tb/gpio/uvm/gpio_reg_pkg.sv is generated from this file:
//     python3 tools/gen/gen_ral.py Design_Docs/regs/gpio.rdl tb/gpio/uvm/gpio_reg_pkg.sv
// =============================================================================
addrmap gpio {
    name = "GPIO";
    desc = "Two-pin GPIO, APB window 7 (0x4000_7000)";
    default regwidth    = 32;
    default accesswidth = 32;

    reg { name = "Direction";
          field { sw = rw; hw = r; reset = 2'b00; desc = "1 = output"; } dir[1:0];
    } PADDIR @ 0x00;
    reg { name = "Input enable";
          field { sw = rw; hw = r; reset = 2'b00; desc = "1 = the pin's input path and interrupt are enabled"; } en[1:0];
    } GPIOEN @ 0x04;
    reg { name = "Pin level";
          field { sw = r; hw = w; desc = "The level on the pin, synchronised"; } pin[1:0];
    } PADIN @ 0x08;
    reg { name = "Output value";
          field { sw = rw; hw = r; reset = 2'b00; } value[1:0];
    } PADOUT @ 0x0C;
    reg { name = "Set output bits";
          field { sw = w; hw = r; desc = "1 sets that bit of PADOUT"; } set[1:0];
    } PADOUTSET @ 0x10;
    reg { name = "Clear output bits";
          field { sw = w; hw = r; desc = "1 clears that bit of PADOUT"; } clr[1:0];
    } PADOUTCLR @ 0x14;
    reg { name = "Interrupt enable per pin";
          field { sw = rw; hw = r; reset = 2'b00; } en[1:0];
    } INTEN @ 0x18;
    reg { name = "Interrupt type, two bits per pin";
          field { sw = rw; hw = r; reset = 2'b00; desc = "00 falling, 01 rising, 10 either edge, 11 level"; } pin0[1:0];
          field { sw = rw; hw = r; reset = 2'b00; } pin1[3:2];
    } INTTYPE @ 0x1C;
    reg { name = "Interrupt status per pin";
          field { sw = r; onread = rclr; hw = w; reset = 2'b00; desc = "Which pin; cleared by reading"; } pin[1:0];
    } INTSTATUS @ 0x24;
    reg { name = "Pad configuration";
          field { sw = rw; hw = r; reset = 4'h0; desc = "No effect: there are no pad cells in RTL"; } pin0[3:0];
          field { sw = rw; hw = r; reset = 4'h0; } pin1[7:4];
    } PADCFG0 @ 0x28;

    reg { name = "Interrupt status";
          field { sw = rw; onwrite = woclr; hw = w; reset = 1'b0; desc = "A GPIO interrupt occurred"; } gpio[0:0];
    } IRQSTAT @ 0xFE0;
    reg { name = "Interrupt enable";
          field { sw = rw; hw = r; reset = 1'b0; } en[0:0];
    } IRQEN @ 0xFE4;
    reg { name = "DMA request control";
          field { sw = rw; hw = r; reset = 2'b00; desc = "Present in every window; the GPIO has no DMA channel"; } req[1:0];
    } DMACTL @ 0xFE8;
    reg { name = "Block identity";
          field { sw = r; hw = na; reset = 32'h6A5D_1301; desc = "0x6A5D, block number 19, revision 1"; } value[31:0];
    } ID @ 0xFEC;
};
